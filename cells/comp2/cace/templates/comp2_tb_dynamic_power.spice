* CACE Dynamic Switching Power and Peak Current Testbench
.include $PDKPATH/libs.tech/ngspice/design.ngspice
.lib $PDKPATH/libs.tech/ngspice/sm141064.ngspice {corner}

.include {netlist}

X1 VDD L A E G B VSS {cell_name}

VPOWER VDD 0 DC {vdd}
VGND VSS 0 DC 0

* Stimuli: Single-input transition sequence
VA A 0 PWL(0 0 9.9n 0 10.1n {vdd} 19.9n {vdd} 20.1n 0 25n 0)
VB B 0 PWL(0 0 4.9n 0 5.1n {vdd} 14.9n {vdd} 15.1n 0 25n 0)

CL L 0 50f
CE E 0 50f
CG G 0 50f

.tran 100p 25n
.control
  run
  let idd = -i(VPOWER)
  meas tran i_peak MAX idd from=1n to=25n
  meas tran i_avg AVG idd from=1n to=25n
  let p_dynamic = i_avg * {vdd}
  print i_peak p_dynamic
  echo "$&i_peak" > comp2_tb_dynamic_0.data
  echo "$&p_dynamic" > comp2_tb_dynamic_power_0.data
.endc

.GLOBAL 0
.end
